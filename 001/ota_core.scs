// =============================================================================
// ota_core.scs - Fully differential two-stage OTA for a 14-bit pipeline-ADC MDAC
//
// Architecture:
//   Stage 1 : NMOS-input folded cascode. Each PMOS cascode uses a local
//             five-transistor error amplifier and an NMOS source follower for
//             gain boosting.
//   Stage 2 : NMOS common-source stage with a PMOS current-source load.
//   Compensation: 0.95 pF Miller capacitor and 130 ohm nulling resistor per side.
//   Reset    : Active-high switch equalizes the two first-stage output nodes.
//   CMFB1    : Regulates the first-stage output common mode through the bottom
//              NMOS current sinks.
//   CMFB2    : Regulates the final output common mode through the second-stage
//              PMOS load gates.
//   Biasing  : All internal bias currents are derived from one external 20 uA
//              reference current.
//
// Device models used:
//   nch_ulvt_mac, pch_ulvt_mac
//
// Loop probes:
//   ipcm1  - first-stage common-mode loop
//   ipcm2  - output common-mode loop
//   ipbsta - positive-side PMOS-cascode boost loop
//   ipbstb - negative-side PMOS-cascode boost loop
// =============================================================================
simulator lang=spectre

// Subcircuit port order: (vdd, vss, in_p, in_n, out_p, out_n, i_bias, reset).
subckt ota_core (vdd vss in_p in_n out_p out_n i_bias reset)

// =============================================================================
// Bias generation
// All four-terminal MOS instances below use: (drain, gate, source, bulk).
// Two-terminal passive instances use: (terminal_1, terminal_2).
// =============================================================================

// The external 20 uA reference is diode-connected at i_bias.
mbd0   (i_bias i_bias vss vss) nch_ulvt_mac l=300n w=4u multi=1 nf=2

// PMOS reference branch used to generate the weak PMOS bias.
mbn1   (p_bias_ref i_bias vss vss) nch_ulvt_mac l=300n w=4u multi=1 nf=2
mbpd0  (p_bias_ref p_bias_ref vdd vdd) pch_ulvt_mac l=300n w=6u multi=1 nf=3

// Low-VDSAT NMOS and PMOS bias rails for low-headroom current sources.
mbpsw  (n_weak_bias p_bias_ref vdd vdd) pch_ulvt_mac l=300n w=6u multi=1 nf=3
mbdw   (n_weak_bias n_weak_bias vss vss) nch_ulvt_mac l=300n w=16u multi=1 nf=8
mbnw2  (p_weak_bias i_bias vss vss) nch_ulvt_mac l=300n w=4u multi=1 nf=2
mbpdw  (p_weak_bias p_weak_bias vdd vdd) pch_ulvt_mac l=300n w=24u multi=1 nf=12

// PMOS bias for the top current sources. The reduced current density keeps the
// top current sources in saturation at the nominal operating point.
mbn2   (p_top_bias n_weak_bias vss vss) nch_ulvt_mac l=300n w=16u multi=1 nf=8
mbpd1  (p_top_bias p_top_bias vdd vdd) pch_ulvt_mac l=300n w=0.90u multi=1 nf=1

// Fold-node reference based on a dense-to-weak PMOS delta-VGS structure.
mbn3   (fold_ref_dense n_weak_bias vss vss) nch_ulvt_mac l=300n w=48u multi=1 nf=24
mprep1 (fold_ref_dense fold_ref_dense vdd vdd) pch_ulvt_mac l=300n w=1.32u multi=1 nf=1
mbps_r (fold_voltage_ref p_bias_ref vdd vdd) pch_ulvt_mac l=300n w=6u multi=1 nf=3
mprep2 (fold_ref_dense fold_ref_dense fold_voltage_ref vdd) pch_ulvt_mac l=100n w=4u multi=1 nf=2

// NMOS-cascode gate bias generated by a replica VGS plus a fixed IR shift.
mbps0  (n_cascode_bias p_weak_bias vdd vdd) pch_ulvt_mac l=300n w=24u multi=1 nf=12
mbnc1  (n_cascode_bias n_cascode_bias n_cascode_bias_source vss) nch_ulvt_mac l=100n w=6.9u multi=1 nf=3
rbnc   (n_cascode_bias_source vss) resistor r=9.5k

// Replica of the second-stage NMOS gate voltage. This is the target common-mode
// voltage for the first-stage outputs.
mbps1  (stage1_cm_ref p_bias_ref vdd vdd) pch_ulvt_mac l=300n w=21u multi=1 nf=10
mrep2  (stage1_cm_ref stage1_cm_ref vss vss) nch_ulvt_mac l=100n w=2.15u multi=1 nf=1

// =============================================================================
// Stage 1: NMOS-input folded cascode
// All four-terminal MOS instances below use: (drain, gate, source, bulk).
// =============================================================================

mtail  (input_pair_source n_weak_bias vss vss) nch_ulvt_mac l=300n w=16u multi=108 nf=8
m1a    (fold_node_p in_p input_pair_source input_pair_source) nch_ulvt_mac l=200n w=90u multi=1 nf=45
m1b    (fold_node_n in_n input_pair_source input_pair_source) nch_ulvt_mac l=200n w=90u multi=1 nf=45

// Top PMOS current sources: approximately 1.43 mA per side at TT/27 C/0.9 V.
mtpa   (fold_node_p p_top_bias vdd vdd) pch_ulvt_mac l=300n w=0.90u multi=76 nf=1
mtpb   (fold_node_n p_top_bias vdd vdd) pch_ulvt_mac l=300n w=0.90u multi=76 nf=1

// Gain-boosted PMOS cascodes.
mpca   (stage1_out_p p_cascode_gate_p fold_node_p fold_node_p) pch_ulvt_mac l=150n w=80u multi=1 nf=40
mpcb   (stage1_out_n p_cascode_gate_n fold_node_n fold_node_n) pch_ulvt_mac l=150n w=80u multi=1 nf=40

// NMOS cascodes and CMFB1-controlled bottom current sinks.
mnca   (stage1_out_p n_cascode_bias n_cascode_source_p vss) nch_ulvt_mac l=100n w=120u multi=1 nf=60
mncb   (stage1_out_n n_cascode_bias n_cascode_source_n vss) nch_ulvt_mac l=100n w=120u multi=1 nf=60
mnsa   (n_cascode_source_p cmfb1_sink_gate vss vss) nch_ulvt_mac l=300n w=80u multi=1 nf=40
mnsb   (n_cascode_source_n cmfb1_sink_gate vss vss) nch_ulvt_mac l=300n w=80u multi=1 nf=40

// =============================================================================
// PMOS-cascode gain boosting
// All four-terminal MOS instances below use: (drain, gate, source, bulk).
// Two-terminal passive instances use: (terminal_1, terminal_2).
// =============================================================================

// Positive-side boost amplifier: fold_node_p is regulated to fold_voltage_ref.
mteaa  (pboost_p_tail n_weak_bias vss vss) nch_ulvt_mac l=300n w=32u multi=1 nf=16
meaa1  (pboost_p_amp_out fold_node_p pboost_p_tail vss) nch_ulvt_mac l=150n w=12u multi=1 nf=6
meaa2  (pboost_p_mirror_node fold_voltage_ref pboost_p_tail vss) nch_ulvt_mac l=150n w=12u multi=1 nf=6
mlaa1  (pboost_p_mirror_node pboost_p_mirror_node vdd vdd) pch_ulvt_mac l=500n w=12u multi=1 nf=6
mlaa2  (pboost_p_amp_out pboost_p_mirror_node vdd vdd) pch_ulvt_mac l=500n w=12u multi=1 nf=6
msfa   (vdd pboost_p_amp_out pboost_p_sf_out vss) nch_ulvt_mac l=60n w=3u multi=1 nf=2
msnka  (pboost_p_sf_out n_weak_bias vss vss) nch_ulvt_mac l=300n w=64u multi=1 nf=32
cbsta  (pboost_p_amp_out vdd) capacitor c=130f

// Negative-side boost amplifier: fold_node_n is regulated to fold_voltage_ref.
mteab  (pboost_n_tail n_weak_bias vss vss) nch_ulvt_mac l=300n w=32u multi=1 nf=16
meab1  (pboost_n_amp_out fold_node_n pboost_n_tail vss) nch_ulvt_mac l=150n w=12u multi=1 nf=6
meab2  (pboost_n_mirror_node fold_voltage_ref pboost_n_tail vss) nch_ulvt_mac l=150n w=12u multi=1 nf=6
mlab1  (pboost_n_mirror_node pboost_n_mirror_node vdd vdd) pch_ulvt_mac l=500n w=12u multi=1 nf=6
mlab2  (pboost_n_amp_out pboost_n_mirror_node vdd vdd) pch_ulvt_mac l=500n w=12u multi=1 nf=6
msfb   (vdd pboost_n_amp_out pboost_n_sf_out vss) nch_ulvt_mac l=60n w=3u multi=1 nf=2
msnkb  (pboost_n_sf_out n_weak_bias vss vss) nch_ulvt_mac l=300n w=64u multi=1 nf=32
cbstb  (pboost_n_amp_out vdd) capacitor c=130f

// Zero-volt loop probes connect the source-follower outputs to the cascode gates.
ipbsta (pboost_p_sf_out p_cascode_gate_p) iprobe
ipbstb (pboost_n_sf_out p_cascode_gate_n) iprobe

// =============================================================================
// Stage 2 and differential reset
// All four-terminal MOS instances below use: (drain, gate, source, bulk).
// Two-terminal passive instances use: (terminal_1, terminal_2).
// =============================================================================

mn2a   (out_p stage1_out_p vss vss) nch_ulvt_mac l=100n w=43u multi=1 nf=20
mn2b   (out_n stage1_out_n vss vss) nch_ulvt_mac l=100n w=43u multi=1 nf=20
mp2a   (out_p cmfb2_load_gate vdd vdd) pch_ulvt_mac l=150n w=52u multi=1 nf=26
mp2b   (out_n cmfb2_load_gate vdd vdd) pch_ulvt_mac l=150n w=52u multi=1 nf=26

// Miller compensation with passive nulling resistors.
rza    (out_p miller_zero_p) resistor r=130
rzb    (out_n miller_zero_n) resistor r=130
cca    (miller_zero_p stage1_out_p) capacitor c=0.95p
ccb    (miller_zero_n stage1_out_n) capacitor c=0.95p

// Active-high reset equalizes the two high-impedance first-stage output nodes.
mrst   (stage1_out_p reset stage1_out_n vss) nch_ulvt_mac l=30n w=6u multi=1 nf=3

// =============================================================================
// CMFB1: first-stage output common-mode control
// All four-terminal MOS instances below use: (drain, gate, source, bulk).
// Two-terminal passive instances use: (terminal_1, terminal_2).
// =============================================================================

// Two differential pairs compare both first-stage outputs with stage1_cm_ref.
mtca   (cmfb1_tail_p n_weak_bias vss vss) nch_ulvt_mac l=300n w=32u multi=1 nf=16
mtcb   (cmfb1_tail_n n_weak_bias vss vss) nch_ulvt_mac l=300n w=32u multi=1 nf=16
mca1   (cmfb1_sense_drain stage1_out_p cmfb1_p_sense_source vss) nch_ulvt_mac l=100n w=12u multi=1 nf=6
mca2   (cmfb1_ref_drain stage1_cm_ref cmfb1_p_ref_source vss) nch_ulvt_mac l=100n w=12u multi=1 nf=6
mcb1   (cmfb1_sense_drain stage1_out_n cmfb1_n_sense_source vss) nch_ulvt_mac l=100n w=12u multi=1 nf=6
mcb2   (cmfb1_ref_drain stage1_cm_ref cmfb1_n_ref_source vss) nch_ulvt_mac l=100n w=12u multi=1 nf=6
rdga   (cmfb1_p_sense_source cmfb1_tail_p) resistor r=1
rdgb   (cmfb1_p_ref_source cmfb1_tail_p) resistor r=1
rdgc   (cmfb1_n_sense_source cmfb1_tail_n) resistor r=1
rdgd   (cmfb1_n_ref_source cmfb1_tail_n) resistor r=1

// PMOS mirror load and error-current output.
mlc1   (cmfb1_sense_drain cmfb1_sense_drain vdd vdd) pch_ulvt_mac l=200n w=6u multi=1 nf=4
mlc2   (cmfb1_ref_drain cmfb1_ref_drain vdd vdd) pch_ulvt_mac l=200n w=6u multi=1 nf=4
mlc3   (cmfb1_control cmfb1_sense_drain vdd vdd) pch_ulvt_mac l=200n w=3u multi=1 nf=2

// Feed-forward current subtraction tracks the required folded-branch current.
msub_p (cmfb1_control p_top_bias vdd vdd) pch_ulvt_mac l=300n w=2.70u multi=1 nf=1
msub_n (cmfb1_control n_weak_bias vss vss) nch_ulvt_mac l=300n w=51.5u multi=1 nf=25

// Cascoded replica of the bottom current sink.
mlc4   (cmfb1_replica_mid cmfb1_control vss vss) nch_ulvt_mac l=300n w=3.2u multi=1 nf=2
mlc5   (cmfb1_control n_cascode_bias cmfb1_replica_mid vss) nch_ulvt_mac l=100n w=4.65u multi=1 nf=2
ccm1   (cmfb1_control vss) capacitor c=100f

// Miller pole splitting around the first-stage common-mode loop.
cm1a   (stage1_out_p cmfb1_control) capacitor c=400f
cm1b   (stage1_out_n cmfb1_control) capacitor c=400f
ipcm1  (cmfb1_control cmfb1_sink_gate) iprobe

// =============================================================================
// CMFB2: final-output common-mode control
// All four-terminal MOS instances below use: (drain, gate, source, bulk).
// Two-terminal passive instances use: (terminal_1, terminal_2).
// =============================================================================

// Resistive output-common-mode sensing and a matched VDD/2 reference.
rsa    (out_p cmfb2_sense_shifted) resistor r=40k
rsb    (out_n cmfb2_sense_shifted) resistor r=40k
csa    (out_p cmfb2_sense_shifted) capacitor c=100f
csb    (out_n cmfb2_sense_shifted) capacitor c=100f
rda    (vdd cmfb2_ref_shifted) resistor r=40k
rdb    (cmfb2_ref_shifted vss) resistor r=40k

// Matched current sinks shift both sensed voltages down by the same amount.
msds   (cmfb2_sense_shifted n_weak_bias vss vss) nch_ulvt_mac l=300n w=7.2u multi=1 nf=3
msdr   (cmfb2_ref_shifted n_weak_bias vss vss) nch_ulvt_mac l=300n w=7.2u multi=1 nf=3

// PMOS-input error amplifier with an NMOS mirror load.
mtp2   (cmfb2_tail p_weak_bias vdd vdd) pch_ulvt_mac l=300n w=48u multi=2 nf=24
mc2a   (cmfb2_mirror_node cmfb2_sense_shifted cmfb2_tail vdd) pch_ulvt_mac l=100n w=10u multi=1 nf=5
mc2b   (cmfb2_control cmfb2_ref_shifted cmfb2_tail vdd) pch_ulvt_mac l=100n w=10u multi=1 nf=5
mld1   (cmfb2_mirror_node cmfb2_mirror_node vss vss) nch_ulvt_mac l=200n w=2u multi=1 nf=1
mld2   (cmfb2_control cmfb2_mirror_node vss vss) nch_ulvt_mac l=200n w=2u multi=1 nf=1
ccm2   (cmfb2_control vdd) capacitor c=0.2p

// Miller pole splitting around the final-output common-mode loop.
cm2a   (out_p cmfb2_control) capacitor c=220f
cm2b   (out_n cmfb2_control) capacitor c=220f
ipcm2  (cmfb2_control cmfb2_load_gate) iprobe

// =============================================================================
// Bias-node decoupling
// Two-terminal passive instances use: (terminal_1, terminal_2).
// =============================================================================

cdvbn  (i_bias vss) capacitor c=0.5p
cdvbp  (p_bias_ref vdd) capacitor c=0.5p
cdvbhd (p_top_bias vdd) capacitor c=0.5p
cdprep (fold_voltage_ref vdd) capacitor c=0.3p
cdvref (stage1_cm_ref vss) capacitor c=0.3p
cdbnc  (n_cascode_bias vss) capacitor c=0.2p

ends ota_core
