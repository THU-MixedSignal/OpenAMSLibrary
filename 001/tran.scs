// Simplified W/L/nf DUT with the shared residue-transient testbench.
simulator lang=spectre
include "ota_core.scs"
include "tb_tran.scs"
