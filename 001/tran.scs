// Standalone MDAC residue transient deck
// Default condition: TT, 27 C, VDD = 0.9 V
simulator lang=spectre
global 0
parameters vddval=0.9 vcmival=0.66 vres=0 vswing=0 csv=3.7p cfv=462.5f clv=500f rfv=80k rsv=10k

// PDK setup:
// Replace only the path inside quotation marks with the corresponding master
// Spectre model deck in your local TSMC 28 nm PDK installation. The selected
// file must define the five sections used below.
include "/path/to/your/TSMC28_PDK/models/spectre/crn28ull_1d8_elk_v1d8_2p2_shrink0d9_embedded_usage.scs" section=pre_simu
include "/path/to/your/TSMC28_PDK/models/spectre/crn28ull_1d8_elk_v1d8_2p2_shrink0d9_embedded_usage.scs" section=noise_worst
include "/path/to/your/TSMC28_PDK/models/spectre/crn28ull_1d8_elk_v1d8_2p2_shrink0d9_embedded_usage.scs" section=TTMacro_MOS_MOSCAP
include "/path/to/your/TSMC28_PDK/models/spectre/crn28ull_1d8_elk_v1d8_2p2_shrink0d9_embedded_usage.scs" section=TT_RES_BIP_DIO_DISRES
include "/path/to/your/TSMC28_PDK/models/spectre/crn28ull_1d8_elk_v1d8_2p2_shrink0d9_embedded_usage.scs" section=TT_MOM

include "ota_core.scs"
// ======================= TB ========================
// ============================================================================
// MDAC residue transient testbench.
// Two-phase timing at 100 MS/s: PH1 resets the summing nodes to VCMI and
// shorts the differential outputs. A 0.4 ns non-overlap interval precedes
// the 5.0 ns amplification phase.
// PWL sources drive the CDAC bottom plates. The differential residue sequence
// covers nominal maximum values, redundancy limits, small residues,
// worst-case polarity reversal, and large-to-small memory behavior.
// Relay elements model ideal testbench switches.
// ============================================================================
simulator lang=spectre

vdd_s (vddn 0) vsource dc=vddval
vcmis (vcmi 0) vsource dc=vcmival

ib1   (vddn ibn1) isource dc=20u
xtr   (vddn 0 sna snb outp outn ibn1 ph1) ota_core

// CDAC, feedback network, and output load.
csa (bpa sna) capacitor c=csv
csb (bpb snb) capacitor c=csv
cfa (sna outn) capacitor c=cfv
cfb (snb outp) capacitor c=cfv
clp (outp 0) capacitor c=clv
cln (outn 0) capacitor c=clv

// Reset switches close while PH1 is high.
vph1  (ph1 0) vsource type=pulse val0=0.9 val1=0 delay=4.6n rise=50p \
      fall=50p width=5.35n period=10n
swia (sna vcmi ph1 0) relay ropen=1e9 rclosed=2 vt1=0.4 vt2=0.5
swib (snb vcmi ph1 0) relay ropen=1e9 rclosed=2 vt1=0.4 vt2=0.5
swod (outp outn ph1 0) relay ropen=1e9 rclosed=2 vt1=0.4 vt2=0.5

// ==================== analyses =====================
simulatorOptions options psfversion="1.4.0" reltol=1e-4 vabstol=1e-6 \
    iabstol=1e-12 temp=27 tnom=27 scalem=1.0 scale=1.0 gmin=1e-12 rforce=1 \
    maxnotes=5 maxwarns=5 digits=5 cols=80 pivrel=1e-3

vbta (bpa 0) vsource type=pwl wave=[0.0000e+00 0.660000 5.0000e-09 0.660000 5.0500e-09 0.674063 1.0000e-08 0.674063 1.0050e-08 0.660000 1.5000e-08 0.660000 1.5050e-08 0.645938 2.0000e-08 0.645938 2.0050e-08 0.660000 2.5000e-08 0.660000 2.5050e-08 0.688125 3.0000e-08 0.688125 3.0050e-08 0.660000 3.5000e-08 0.660000 3.5050e-08 0.631875 4.0000e-08 0.631875 4.0050e-08 0.660000 4.5000e-08 0.660000 4.5050e-08 0.661758 5.0000e-08 0.661758 5.0050e-08 0.660000 5.5000e-08 0.660000 5.5050e-08 0.631875 6.0000e-08 0.631875 6.0050e-08 0.660000 6.5000e-08 0.660000 6.5050e-08 0.688125 7.0000e-08 0.688125 7.0050e-08 0.660000 7.5000e-08 0.660000 7.5050e-08 0.658242 8.0000e-08 0.658242 8.0050e-08 0.660000]
vbtb (bpb 0) vsource type=pwl wave=[0.0000e+00 0.660000 5.0000e-09 0.660000 5.0500e-09 0.645938 1.0000e-08 0.645938 1.0050e-08 0.660000 1.5000e-08 0.660000 1.5050e-08 0.674063 2.0000e-08 0.674063 2.0050e-08 0.660000 2.5000e-08 0.660000 2.5050e-08 0.631875 3.0000e-08 0.631875 3.0050e-08 0.660000 3.5000e-08 0.660000 3.5050e-08 0.688125 4.0000e-08 0.688125 4.0050e-08 0.660000 4.5000e-08 0.660000 4.5050e-08 0.658242 5.0000e-08 0.658242 5.0050e-08 0.660000 5.5000e-08 0.660000 5.5050e-08 0.688125 6.0000e-08 0.688125 6.0050e-08 0.660000 6.5000e-08 0.660000 6.5050e-08 0.631875 7.0000e-08 0.631875 7.0050e-08 0.660000 7.5000e-08 0.660000 7.5050e-08 0.661758 8.0000e-08 0.661758 8.0050e-08 0.660000]

tran1 tran stop=8.0e-08 errpreset=conservative \
    maxstep=20p annotate=status
finalTimeOP info what=oppoint where=rawfile

save outp outn sna snb bpa ph1 vdd_s:p \
    xtr.stage1_out_p xtr.stage1_out_n xtr.cmfb1_control xtr.cmfb2_control \
    xtr.fold_node_p xtr.fold_node_n xtr.input_pair_source \
    xtr.p_cascode_gate_p xtr.n_cascode_source_p \
    xtr.cmfb2_sense_shifted xtr.cmfb2_ref_shifted
saveOptions options save=selected
