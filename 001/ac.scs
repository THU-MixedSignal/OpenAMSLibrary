// Simplified W/L/nf DUT with the shared AC/STB/noise testbench.
simulator lang=spectre
include "ota_core.scs"
include "tb_ac.scs"
