// Full CDF-geometry DUT with the shared residue-transient testbench.
simulator lang=spectre
include "ota_core_full_geometry.scs"
include "tb_tran.scs"
